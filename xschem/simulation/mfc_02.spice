** sch_path: /home/ttuser/Mfcs/mfc_02/xschem/mfc_02.sch
.subckt mfc_02 gate sbd
*.PININFO gate:I sbd:O
XM2 sbd gate sbd sbd sky130_fd_pr__nfet_01v8 L=0.15 W=1.68 nf=1 m=1
.ends
.end
